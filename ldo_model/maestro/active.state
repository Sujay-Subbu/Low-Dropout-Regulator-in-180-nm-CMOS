ADE simulation setup
Test ece483_sp23_ldo_model_1: ece483_sp25/ldo_model/schematic, simulator spectre
  Models: /class/ece483/models/models_ece483
  Variables: Aea = 3000; Co1 = 80f; Cout = 200p; Gm1 = 1m; Iload = 20m; Lp = 360n; Wp = 1.3u; Rf1 = 10k; Rf2 = 20k; VIN = 1.8; vin = 1; VREF = 800m; vref = 0; Cmiller = 1p
  Temperature: 27
  Analysis stb: start=1 stop=10G dec=101 probe=/VSTB stbProbeMode=differential localgnd=/net1
  Analysis tran: stop=20u
  Analysis dc: (saves the operating point)
  Output Loop Gain Phase = phaseDegUnwrapped(getData("loopGain" ?result "stb"))
  Output Loop Gain dB20 = db(mag(getData("loopGain" ?result "stb")))
  Output Phase Margin = getData("phaseMargin" ?result "stb_margin")
  Output Gain Margin = getData("gainMargin" ?result "stb_margin")
  Output Vout_tran = VT("/Vout")
Run mode: Single Run, Sweeps and Corners
Specs:
  ece483_sp23_ldo_model_1 / Phase Margin: > 60
Setup values for test ece483_sp23_ldo_model_1: Cmiller = {From/To}Linear:1p:10p:100p{From/To}

ADE simulation setup
Run mode: Single Run, Sweeps and Corners
Tests:
  ece483_sp23_ldo_model_1: ece483_sp25/ldo_model/schematic, simulator spectre
    Variables: Aea = 3000; Co1 = 80f; Cout = 200p; Gm1 = 1m; Iload = 20m; Lp = 360n; Wp = 1.3u; Rf1 = 10k; Rf2 = 20k; VIN = 1.8; vin = 1; VREF = 800m; vref = 0; Cmiller = {From/To}Linear:1p:10p:100p{From/To}
    Outputs: Vout_tran
Specs:
  ece483_sp23_ldo_model_1 / Phase Margin: > 60

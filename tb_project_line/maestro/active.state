ADE simulation setup
Test ece483_sp25_tb_project_line_1: ece483_sp25/tb_project_line/schematic, simulator spectre
  Models: /class/ece483/models/models_ece483
  Variables: C2 = 7p; Cout = 200p; Iload = 20m; Lp = 180n; Rf1 = 10k; Rf2 = 20k; VIN = 1.8; vin = 0; VREF = 0.8; vref = 0; Wp = 1.3u
  Temperature: 27
  Analysis dc: (saves the operating point)
  Output Line Regulation = (1.2 - VDC("/Vout"))
Run mode: Single Run, Sweeps and Corners
Setup values for test ece483_sp25_tb_project_line_1: VIN = {Inclusion List}1.8{Inclusion List}{From/To}Linear:1.62:0.001:1.98{From/To}

ADE simulation setup
Run mode: Single Run, Sweeps and Corners
Tests:
  ece483_sp25_tb_project_line_1: ece483_sp25/tb_project_line/schematic, simulator spectre
    Variables: C2 = 7p; Cout = 200p; Iload = 20m; Lp = 180n; Rf1 = 10k; Rf2 = 20k; VIN = {Inclusion List}1.8{Inclusion List}{From/To}Linear:1.62:0.001:1.98{From/To}; vin = 0; VREF = 0.8; vref = 0; Wp = 1.3u
    Outputs: Line Regulation

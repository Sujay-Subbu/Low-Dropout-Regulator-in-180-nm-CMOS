ADE simulation setup
Test ece483_sp25_tb_project_load_1: ece483_sp25/tb_project_load/schematic, simulator spectre
  Models: /class/ece483/models/models_ece483
  Variables: W1 = 6u; Iload = 20m; Lp = 180n; Cout = 200p; Rf1 = 10k; Rf2 = 20k; VIN = 1.8; vin = 0; VREF = 0.8; vref = 0; Wp = 1.3u; C2 = 7p
  Temperature: 27
  Analysis dc: (saves the operating point)
  Output Load Regulation = (1.2 - VDC("/Vout"))
Run mode: Single Run, Sweeps and Corners
Setup values for test ece483_sp25_tb_project_load_1: Iload = {Inclusion List}20m{Inclusion List}{From/To}Linear:5m:0.01m:10m{From/To}

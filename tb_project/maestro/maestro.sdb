ADE simulation setup
Run mode: Single Run, Sweeps and Corners
Tests:
  ece483_sp25_tb_project_1: ece483_sp25/tb_project/schematic, simulator spectre
    Variables: Cout = 200p; Iload = 20m; Rf1 = 10k; Rf2 = 20k; VIN = 1.8; vin = 0.18; VREF = 0.800; vref = 0; Lp = 180n; Wp = 1.3u; C1 = 0p; C2 = 7p
    Outputs: Loop Gain Phase; Loop Gain dB20; Phase Margin; Gain Margin; Vout_tran; Vin_tran
Specs:
  ece483_sp25_tb_project_1 / Phase Margin: > 60

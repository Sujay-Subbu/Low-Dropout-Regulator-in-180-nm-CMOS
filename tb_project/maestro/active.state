ADE simulation setup
Test ece483_sp25_tb_project_1: ece483_sp25/tb_project/schematic, simulator spectre
  Models: /class/ece483/models/models_ece483
  Variables: Cout = 200p; Iload = 20m; Rf1 = 10k; Rf2 = 20k; VIN = 1.8; vin = 0.18; VREF = 0.800; vref = 0; Lp = 180n; Wp = 1.3u; C1 = 0p; C2 = 7p
  Temperature: 27
  Analysis stb: start=1 stop=10G dec=101 probe=/STB_PRB stbProbeMode=differential localgnd=/VSS
  Analysis dc: (saves the operating point)
  Analysis tran: stop=20u errpreset=moderate
  Output Loop Gain Phase = phaseDegUnwrapped(getData("loopGain" ?result "stb"))
  Output Loop Gain dB20 = db(mag(getData("loopGain" ?result "stb")))
  Output Phase Margin = getData("phaseMargin" ?result "stb_margin")
  Output Gain Margin = getData("gainMargin" ?result "stb_margin")
  Output Vout_tran = VT("/Vout")
  Output Vin_tran = VT("/Vin")
  Output I_tran = IT("/Rload/PLUS")
  Output VT("/ECE483_LDO/Vg")
  Output Quiescent Current = IDC("/ECE483_LDO/R0/PLUS")
  Signals: /Rload/PLUS (terminal), /ECE483_LDO/R0/PLUS (terminal)
Run mode: Single Run, Sweeps and Corners
Specs:
  ece483_sp25_tb_project_1 / Phase Margin: > 60

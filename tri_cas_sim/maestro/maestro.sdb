ADE simulation setup
Run mode: Single Run, Sweeps and Corners
Tests:
  ece483_sp25_tri_cas_sim_1: ece483_sp25/tri_cas_sim/schematic, simulator spectre
    Variables: VCM = 0.8; VDD = 1.8; VSS = 0
    Outputs: A; A0

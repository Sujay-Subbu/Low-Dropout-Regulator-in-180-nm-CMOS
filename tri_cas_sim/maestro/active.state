ADE simulation setup
Test ece483_sp25_tri_cas_sim_1: ece483_sp25/tri_cas_sim/schematic, simulator spectre
  Models: /class/ece483/models/models_ece483
  Variables: VCM = 0.8; VDD = 1.8; VSS = 0
  Temperature: 27
  Analysis dc: (saves the operating point)
  Analysis ac: start=1 stop=1G dec=201
  Output A = dB20(VF("vout"))
  Output A0 = value(A 1)
Run mode: Single Run, Sweeps and Corners
